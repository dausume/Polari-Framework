.title KiCad schematic
.include "illustrative-led.lib"
.tran 10u 80m
V1 /LED_CONTROL 0 PULSE( 0 5 5m 10u 10u 20m 40m )
R1 /LED_CONTROL /LED_ANODE 220
D1 0 /LED_ANODE polari_demo_led
.end
