// toyperiph - hal-4's "our own RTL" stand-in (econ, 2026-11-13): a tiny peripheral described the way our own silicon will be,
// SystemRDL 2.0 -> (PeakRDL) -> CMSIS-SVD -> board.custom.svd_import. One field of each access kind the HAL distinguishes.
addrmap toyperiph {
    name = "Toy peripheral (own-RTL stand-in)";
    default regwidth = 32;
    default accesswidth = 32;

    reg {
        name = "GPIO output";
        field { desc = "Output level of pins 0-7."; sw = rw; hw = r; } out[8] = 0;
    } gpio_out @ 0x0;

    reg {
        name = "Control";
        field { desc = "Enable the peripheral."; sw = rw; hw = r; } en[0:0] = 0;
        field { desc = "Operating mode: 0 idle, 1 run, 2 step, 3 test."; sw = rw; hw = r; } mode[2:1] = 0;
        field { desc = "Write 1 to start a calibration; hardware clears it when the calibration is done."; sw = rw; hw = r; hwclr; } start[3:3] = 0;
    } ctrl @ 0x4;

    reg {
        name = "Status";
        field { desc = "Set by hardware when an operation completes; write 1 to clear."; sw = rw; hw = w; hwset; onwrite = woclr; } done[0:0] = 0;
    } status @ 0x8;

    reg {
        name = "Command";
        field { desc = "Write 1 to start one operation; reads as 0 (clears itself after one cycle)."; sw = w; hw = r; singlepulse; } go[0:0] = 0;
    } cmd @ 0xC;

    reg {
        name = "Counter";
        field { desc = "Operations completed since reset."; sw = r; hw = w; } count[15:0] = 0;
    } count @ 0x10;
};
